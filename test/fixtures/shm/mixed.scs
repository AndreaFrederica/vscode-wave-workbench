// SPDX-License-Identifier: MPL-2.0
simulator lang=spectre
timeDom tran stop=20n maxstep=100p
amsd {
}
